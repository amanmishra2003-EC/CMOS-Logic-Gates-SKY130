** sch_path: /mnt/d/EDA/projects/analog/nor/nor.sch
**.subckt nor A B Y B
*.ipin A
*.ipin B
*.opin Y
*.ipin B
XM1 Y B GND GND sky130_fd_pr__nfet_01v8 L=0.15 W=1 nf=1 ad=0.29 as=0.29 pd=2.58 ps=2.58 nrd=0.29 nrs=0.29 sa=0 sb=0 sd=0 mult=1
XM2 Y A GND GND sky130_fd_pr__nfet_01v8 L=0.15 W=1 nf=1 ad=0.29 as=0.29 pd=2.58 ps=2.58 nrd=0.29 nrs=0.29 sa=0 sb=0 sd=0 mult=1
VDD VDD GND 1.8
VA A GND PULSE(0 1.8 0n 100p 100p 10n 20n)
VB B GND PULSE(0 1.8 0n 100p 100p 20n 40n)
XM3 net1 A VDD VDD sky130_fd_pr__pfet_01v8 L=0.15 W=1 nf=1 ad=0.29 as=0.29 pd=2.58 ps=2.58 nrd=0.29 nrs=0.29 sa=0 sb=0 sd=0 mult=1
XM4 Y B net1 VDD sky130_fd_pr__pfet_01v8 L=0.15 W=1 nf=1 ad=0.29 as=0.29 pd=2.58 ps=2.58 nrd=0.29 nrs=0.29 sa=0 sb=0 sd=0 mult=1
**** begin user architecture code

.lib /mnt/d/EDA/pdk/open_pdks/sky130/sky130A/libs.tech/ngspice/sky130.lib.spice tt
.control
save all
tran 100p 80n
run
plot v(A) v(B) v(Y)
.endc

**** end user architecture code
**.ends
.GLOBAL GND
.end
